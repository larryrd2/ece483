ADE simulation setup
Run mode: Single Run, Sweeps and Corners
Tests:
  ece483_sp23_tb_mp1_1: ece483_sp23/tb_mp1/schematic, simulator spectre
    Variables: CL = 2p; VDD = 1.8; VSS = 0
    Outputs: AvdB; A0; Av; w3dB; VOUT
Specs:
  ece483_sp23_tb_mp1_1 / A0: target 5, tolerance 2%
  ece483_sp23_tb_mp1_1 / w3dB: > 50M
  ece483_sp23_tb_mp1_1 / VOUT: target 0.9, tolerance 2%

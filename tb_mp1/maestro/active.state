ADE simulation setup
Test ece483_sp23_tb_mp1_1: ece483_sp23/tb_mp1/schematic, simulator spectre
  Models: /class/ece483/models/models_ece483
  Variables: CL = 2p; VDD = 1.8; VSS = 0
  Temperature: 27
  Analysis ac: start=1 stop=1G dec=201
  Analysis dc: (saves the operating point)
  Output Av = VF("/vout") (unticked)
  Output AvdB = dB20(Av)
  Output A0 = mag(value(Av 1))
  Output w3dB = (2 * pi * cross(AvdB (dB20(A0) - 3) 1))
  Output VOUT = VDC("/vout")
Test ece483_sp23_tb_mp1_1: ece483_sp23/tb_mp1/schematic, simulator spectre
  Models: /class/ece483/models/models_ece483
  Variables: CL = 2p; VDD = 1.8; VSS = 0
  Temperature: 27
  Analysis dc: (saves the operating point)
  Analysis ac: start=1 stop=1G dec=201
  Output Av = VF("/vout") (unticked)
  Output AvdB = dB20(Av)
  Output A0 = mag(value(Av 1))
  Output w3dB = (2 * pi * cross(AvdB (dB20(A0) - 3) 1))
  Output VOUT = VDC("/vout")
Run mode: Single Run, Sweeps and Corners
Specs:
  ece483_sp23_tb_mp1_1 / A0: target 5, tolerance 2%
  ece483_sp23_tb_mp1_1 / w3dB: > 50M
  ece483_sp23_tb_mp1_1 / VOUT: target 0.9, tolerance 2%

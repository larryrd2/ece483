ADE simulation setup
Test ece483_sp23_ldo_model_1: ece483_sp23/ldo_model/schematic, simulator spectre
  Models: /class/ece483/models/models_ece483
  Variables: Aea = 10; Co1 = 200f; Cout = 200p; Gm1 = 100u; Iload = 1m; Rf1 = 1k; Rf2 = 1k; VIN = 1.8; vin = 0; VREF = 0.6; vref = 0; Lp = 270n; Wp = 1u; f = 4.01; R = 30k; div = 4; g3 = 16/div; p2 = 270n*div; g2 = 21.1/div; g1 = 37.5/div; g = 1/div
  Temperature: 27
  Analysis dc: sweep VIN start=0 stop=3 (saves the operating point)
  Analysis tran: stop=20u errpreset=moderate
  Analysis stb: start=1 stop=10G probe=/VSTB stbProbeMode=differential
  Output Loop Gain Phase = phaseDegUnwrapped(getData("loopGain" ?result "stb"))
  Output Loop Gain dB20 = db(mag(getData("loopGain" ?result "stb")))
  Output Phase Margin = getData("phaseMargin" ?result "stb_margin")
  Output Gain Margin = getData("gainMargin" ?result "stb_margin")
  Output Vout_tran = VT("/Vout")
  Output Line/Load Regulation = VS("/Vout")
  Output I_load = IDC("/Rload/PLUS")
  Output quiescent = (IDC("/P0/S") - IDC("/Rload/PLUS"))
  Output IDC("/net8")
  Output IDC("/net24")
  Output IDC("/BN1")
  Output IDC("/I4/N3/D")
  Output IDC("/I4/N2/D")
  Output IDC("/I4/N7/D")
  Output IDC("/I4/P1/S")
  Output IDC("/I4/P8/S")
  Output res_i = IDC("/I4/R4/PLUS")
  Output IDC("/I4/I27/PLUS")
  Output IDC("/I4/P12/G")
  Output IDC("/I4/P8/G")
  Output IDC("/I4/P7/G")
  Output IDC("/I4/P1/G")
  Output IDC("/I4/P11/G")
  Output IDC("/I4/R4/MINUS")
  Output IDC("/I4/P11/S")
  Signals: /Rload/PLUS (terminal), /P0/S (terminal), /Vin, /I4/N3/D (terminal), /I4/N2/D (terminal), /I4/N7/D (terminal), /I4/P1/S (terminal), /I4/P8/S (terminal), /I4/R4/PLUS (terminal), /I4/I27/PLUS (terminal), /I4/P12/G (terminal), /I4/P8/G (terminal), /I4/P7/G (terminal), /I4/P1/G (terminal), /I4/P11/G (terminal), /I4/R4/MINUS (terminal), /I4/P11/S (terminal)
Test ece483_sp24_ldo_model_1: ece483_sp23/ldo_model/schematic, simulator spectre
  Models: /class/ece483/models/models_ece483
  Variables: Aea = 10; Co1 = 200f; Cout = 200p; Gm1 = 100u; Iload = 1m; Rf1 = 1k; Rf2 = 1k; VIN = 1.8; vin = 0; VREF = 0.6; vref = 0; Lp = 270n; Wp = 1u; f = 4.01; R = 30k; div = 4; g3 = 16/div; p2 = 270n*div; g2 = 21.1/div; g1 = 37.5/div; g = 1/div
  Temperature: 27
  Analysis dc: sweep VIN start=0 stop=3 (saves the operating point)
  Analysis tran: stop=20u errpreset=moderate
  Analysis stb: start=1 stop=10G probe=/VSTB stbProbeMode=differential
  Output Loop Gain Phase = phaseDegUnwrapped(getData("loopGain" ?result "stb"))
  Output Loop Gain dB20 = db(mag(getData("loopGain" ?result "stb")))
  Output Phase Margin = getData("phaseMargin" ?result "stb_margin")
  Output Gain Margin = getData("gainMargin" ?result "stb_margin")
  Output Vout_tran = VT("/Vout")
  Output Line/Load Regulation = VS("/Vout")
  Output I_load = IDC("/Rload/PLUS")
  Output quiescent = (IDC("/P0/S") - IDC("/Rload/PLUS"))
  Output IDC("/net8")
  Output IDC("/net24")
  Output IDC("/BN1")
  Output IDC("/I4/N3/D")
  Output IDC("/I4/N2/D")
  Output IDC("/I4/N7/D")
  Output IDC("/I4/P1/S")
  Output IDC("/I4/P8/S")
  Output res_i = IDC("/I4/R4/PLUS")
  Output IDC("/I4/I27/PLUS")
  Output IDC("/I4/P12/G")
  Output IDC("/I4/P8/G")
  Output IDC("/I4/P7/G")
  Output IDC("/I4/P1/G")
  Output IDC("/I4/P11/G")
  Output IDC("/I4/R4/MINUS")
  Output IDC("/I4/P11/S")
  Signals: /Vin

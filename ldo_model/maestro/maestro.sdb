ADE simulation setup
Run mode: Single Run, Sweeps and Corners
Tests:
  ece483_sp23_ldo_model_1: ece483_sp23/ldo_model/schematic, simulator spectre
    Variables: Aea = 10; Co1 = 200f; Cout = 200p; Gm1 = 100u; Iload = 1m; Rf1 = 1k; Rf2 = 1k; VIN = 1.8; vin = 0; VREF = 0.6; vref = 0; Lp = 270n; Wp = 1u; f = 4.01; g = 1/div; g1 = 37.5/div; g2 = 21.1/div; p2 = 270n*div; R = 30k; g3 = 16/div; div = 4
    Outputs: Vout_tran; I_load; "/IDC(\"/net8\")"; /Vg; "/I4/net9"; /I4/net9; IDC("/net8"); IDC("/net24"); IDC("/BN1")
Specs:
  ece483_sp23_ldo_model_1 / Vout_tran: range 1 to 1.4
  ece483_sp23_ldo_model_1 / Line/Load Regulation: < 500u
  ece483_sp23_ldo_model_1 / I_load: range .1m to 10m
  ece483_sp23_ldo_model_1 / quiescent: < 100u
